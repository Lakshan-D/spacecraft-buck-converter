* Same power stage, load step 0.3A -> 3A at 1ms (open loop). Shows weakly damped LC ringing.
.param Vin=28
.param fsw=200k
.param Duty=0.19
.param RonFET=0.05
.param Rdcr=0.02
.param Resr=0.005

Vsrc  src 0 DC {Vin}
Rsrc  src vin 0.01
Cin   vin 0 20u ic={Vin}
Vpwm  ctl 0 PULSE(0 5 0 10n 10n {Duty/fsw} {1/fsw})
S1    vin sw ctl 0 SWMOD
.model SWMOD SW(Ron={RonFET} Roff=1Meg Vt=2.5 Vh=0.1)
D1    0 sw DSCH
.model DSCH D(Is=2e-6 N=1.05 Rs=0.015 Cjo=300p Vj=0.5 M=0.5 Bv=60)
L1    sw lx 22u
Rdcr1 lx out {Rdcr}
Cout  out cesr 47u ic=6.5
Resr1 cesr 0 {Resr}

* Light load always on (0.3A), heavy load added at t = 1ms
Rlight out 0 16.67
Vstep stp 0 PULSE(0 5 1m 1u 1u 10 20)
Sload out hl stp 0 SWL
.model SWL SW(Ron=0.001 Roff=1Meg Vt=2.5 Vh=0.1)
Rheavy hl 0 1.852

.tran 10n 2m 0 10n uic
.end
